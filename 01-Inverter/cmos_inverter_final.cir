* CMOS Inverter - Complete Netlist
* Generated from schematic
.title CMOS Inverter

* Power Supply
Vdd vdd 0 DC 5

* Input Signal
Vin in 0 PULSE(0 5 10ns 1ns 1ns 40ns 100ns)

* Load Capacitor
CL out 0 1p

* PMOS Transistor M1 (Pull-up)
* Format: M<name> <drain> <gate> <source> <bulk> <model> W=<width> L=<length>
M1 out in vdd vdd pmod_model W=4u L=1u

* NMOS Transistor M2 (Pull-down)
* Format: M<name> <drain> <gate> <source> <bulk> <model> W=<width> L=<length>
M2 out in 0 0 nmod_model W=2u L=1u

* MOSFET Models
.model nmod_model NMOS (LEVEL=1 VTO=0.7 KP=120u LAMBDA=0.04 TOX=20n)
.model pmod_model PMOS (LEVEL=1 VTO=-0.7 KP=40u LAMBDA=0.05 TOX=20n)

* Transient Analysis: 0 to 300ns with 0.1ns time step
.tran 0 300ns 0 0.1ns

* Measurements
* Propagation Delay High to Low (input rises, output falls)
.meas tran tpHL TRIG V(in) VAL=2.5 RISE=1 TARG V(out) VAL=2.5 FALL=1

* Propagation Delay Low to High (input falls, output rises)
.meas tran tpLH TRIG V(in) VAL=2.5 FALL=1 TARG V(out) VAL=2.5 RISE=1

* Average Propagation Delay
.meas tran tp PARAM='(tpHL+tpLH)/2'

* Rise Time (10% to 90%)
.meas tran trise TRIG V(out) VAL=0.5 RISE=1 TARG V(out) VAL=4.5 RISE=1

* Fall Time (90% to 10%)
.meas tran tfall TRIG V(out) VAL=4.5 FALL=1 TARG V(out) VAL=0.5 FALL=1

* Average Power Dissipation
.meas tran avg_power AVG I(Vdd)*5 FROM=0ns TO=300ns

* Peak Supply Current
.meas tran peak_current MAX I(Vdd)

* Control options
.options abstol=1e-12 reltol=1e-6

.end

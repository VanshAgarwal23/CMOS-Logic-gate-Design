* CMOS Inverter - Simple and Clean
.title CMOS Inverter

Vdd vdd 0 DC 5
Vin in 0 PULSE(0 5 10ns 1ns 1ns 40ns 100ns)
CL out 0 1p

M1 out in vdd vdd PMOS_MODEL
M2 out in 0 0 NMOS_MODEL

.model NMOS_MODEL NMOS (VTO=0.7 KP=20u LAMBDA=0.04)
.model PMOS_MODEL PMOS (VTO=-0.7 KP=10u LAMBDA=0.05)

.tran 0 300ns 0 0.1ns

.meas tran tpHL TRIG V(in) VAL=2.5 RISE=1 TARG V(out) VAL=2.5 FALL=1
.meas tran tpLH TRIG V(in) VAL=2.5 FALL=1 TARG V(out) VAL=2.5 RISE=1
.meas tran tp PARAM='(tpHL+tpLH)/2'
.meas tran avg_power AVG I(Vdd)*5 FROM=0ns TO=300ns
.meas tran peak_current MAX I(Vdd)

.end

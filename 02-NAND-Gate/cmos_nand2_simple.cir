* CMOS 2-Input NAND Gate - Final LTspice Netlist
* LTspice 26.0.2
* Updated with verified propagation-delay and power measurements
*
* Circuit:
* VDD = 5 V
* CL  = 50 fF
* PMOS M1/M2 = 4u/1u
* NMOS M3/M4 = 2u/1u

Vdd N001 0 5
Vin_A in_a 0 PULSE(0 5 10ns 1ns 1ns 40ns 100ns)
Vin_B in_b 0 5V
CL out 0 50f

* CMOS NAND2 pull-up network: PMOS devices in parallel
M1 out in_a N001 N001 pmos_model W=4u L=1u
M2 out in_b N001 N001 pmos_model W=4u L=1u

* CMOS NAND2 pull-down network: NMOS devices in series
M3 out in_a N002 N002 nmos_model W=2u L=1u
M4 N002 in_b 0 0 nmos_model W=2u L=1u

* MOS models used by the current design
.model nmos_model NMOS (LEVEL=1 VTO=0.7 KP=20u LAMBDA=0.04 TOX=20n)
.model pmos_model PMOS (LEVEL=1 VTO=-0.7 KP=10u LAMBDA=0.05 TOX=20n)

* Standard LTspice MOS library
.lib C:\Users\Test\AppData\Local\LTspice\lib\cmp\standard.mos

* Transient analysis
.tran 0 100n 0 10p

* Propagation-delay measurements
.meas tran tpHL TRIG V(in_a) VAL=2.5 RISE=1 TARG V(out) VAL=2.5 FALL=1
.meas tran tpLH TRIG V(in_a) VAL=2.5 FALL=1 TARG V(out) VAL=2.5 RISE=1

* Power and energy measurements over the complete 100 ns window
.meas tran Pavg AVG (-V(N001)*I(Vdd)) FROM 0 TO 100n
.meas tran Esw INTEG (-V(N001)*I(Vdd)) FROM 0 TO 100n

.backanno
.end
